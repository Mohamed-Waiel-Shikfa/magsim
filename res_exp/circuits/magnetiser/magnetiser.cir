.title KiCad schematic
.include "magnetiser.lib"
XQ4 /COIL_B Net-_Q4-G_ GND CLA100E1200HB
D4 GND /COIL_B DCROWBAR
D3 /COIL_B /VBUS DCROWBAR
RS3 /VBUS Net-_CS3-Pad1_ 50
CS3 Net-_CS3-Pad1_ /COIL_B 22n
XQ3 /VBUS Net-_Q3-G_ /COIL_B CLA100E1200HB
CS2 Net-_CS2-Pad1_ GND 22n
RS2 /COIL_A Net-_CS2-Pad1_ 50
D2 GND /COIL_A DCROWBAR
XQ2 /COIL_A Net-_Q2-G_ GND CLA100E1200HB
RG3 /VBUS Net-_RG3-Pad2_ 2.2k
XQ1 /VBUS Net-_Q1-G_ /COIL_A CLA100E1200HB
XU1 Net-_RLED1-Pad2_ /PICO_GND Net-_Q1-G_ Net-_RG1-Pad2_ VO4258H
RG1 /VBUS Net-_RG1-Pad2_ 2.2k
RLED1 /GP16 Net-_RLED1-Pad2_ 470
RS1 /VBUS Net-_CS1-Pad1_ 50
CS1 Net-_CS1-Pad1_ /COIL_A 22n
D1 /COIL_A /VBUS DCROWBAR
RG4 /COIL_B Net-_RG4-Pad2_ 2.2k
XU4 Net-_RLED4-Pad2_ /PICO_GND Net-_Q4-G_ Net-_RG4-Pad2_ VO4258H
RLED4 /GP16 Net-_RLED4-Pad2_ 470
RGK4 Net-_Q4-G_ GND 1k
RLED3 /GP17 Net-_RLED3-Pad2_ 470
RGK3 Net-_Q3-G_ /COIL_B 1k
XU3 Net-_RLED3-Pad2_ /PICO_GND Net-_Q3-G_ Net-_RG3-Pad2_ VO4258H
RG2 /COIL_A Net-_RG2-Pad2_ 2.2k
RLED2 /GP17 Net-_RLED2-Pad2_ 470
RGK2 Net-_Q2-G_ GND 1k
XU2 Net-_RLED2-Pad2_ /PICO_GND Net-_Q2-G_ Net-_RG2-Pad2_ VO4258H
RGK1 Net-_Q1-G_ /COIL_A 1k
RS4 /COIL_B Net-_CS4-Pad1_ 50
CS4 Net-_CS4-Pad1_ GND 22n
.end
